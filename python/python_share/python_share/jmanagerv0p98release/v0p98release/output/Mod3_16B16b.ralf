#################################################################################
# ralf file generated by Jmanager 
# use vcs - ralgen to generate uvm regmodel 
#usage: 
#    ralgen -l sv -uvm -t  Mod3_16B_regmodel  Mod3_16B16b.ralf
#################################################################################
register REG0B {
    field reg00d  (dout[ 0 ]) {
         bits 1;
         access rw;
         reset 'h0;
    }
    field reg3to2d  (dout[ 3:1 ]) {
         bits 3;
         access rw;
         reset 'h3;
    }
    field reg444d  (NO_USED_PATH_NEED_TO_BE_REMOVED.reg444d) {
         bits 1;
         access ro;
         reset 'h0;
    }
    field reserved {
         bits 1;
    }
    field ab  (dout[ 13:4 ]) {
         bits 10;
         access rw;
         reset 'h1;
    }
}

register REG2B {
    field reg00e  (dout[ 0 ]) {
         bits 1;
         access rw;
         reset 'h0;
    }
    field reg3to2e  (dout[ 3:1 ]) {
         bits 3;
         access rw;
         reset 'h3;
    }
    field reg444e  (NO_USED_PATH_NEED_TO_BE_REMOVED.reg444e) {
         bits 1;
         access ro;
         reset 'h0;
    }
    field reserved {
         bits 1;
    }
    field ac  (dout[ 13:4 ]) {
         bits 10;
         access rw;
         reset 'h1;
    }
}

register REG3B {
    field reg00f  (dout[ 0 ]) {
         bits 1;
         access rw;
         reset 'h0;
    }
    field reg444f  (NO_USED_PATH_NEED_TO_BE_REMOVED.reg444f) {
         bits 2;
         access ro;
         reset 'h0;
    }
    field reserved {
         bits 3;
    }
    field add  (dout[ 10:1 ]) {
         bits 10;
         access rw;
         reset 'h1;
    }
}

register REG4B {
    field m2r4_f0  (dout[ 0 ]) {
         bits 1;
         access rw;
         reset 'h0;
    }
    field m2r4_ro_3b  (NO_USED_PATH_NEED_TO_BE_REMOVED.m2r4_ro_3b) {
         bits 4;
         access ro;
         reset 'h0;
    }
    field reserved {
         bits 1;
    }
    field eaaee4  (dout[ 10:1 ]) {
         bits 10;
         access rw;
         reset 'h1;
    }
}

register REG5B {
    field rw0x5_8b  (dout[ 15:0 ]) {
         bits 16;
         access rw;
         reset 'hfb;
    }
}

register REG6B {
    field ro0x6_8b  (NO_USED_PATH_NEED_TO_BE_REMOVED.ro0x6_8b) {
         bits 16;
         access ro;
         reset 'h1;
    }
}

register REG7B {
    field rw0x7_8b  (dout[ 15:0 ]) {
         bits 16;
         access rw;
         reset 'h1;
    }
}

block Mod3_16B_regmodel {
    bytes 2;
    register REG0B (U_REG0B_0)		@'h0;
    register REG2B (U_REG2B_1)		@'h1;
    register REG3B (U_REG3B_2)		@'h2;
    register REG4B (U_REG4B_3)		@'h3;
    register REG5B (U_REG5B_4)		@'h4;
    register REG6B (U_REG6B_6)		@'h6;
    register REG7B (U_REG7B_7)		@'h7;
}
