#################################################################################
# ralf file generated by Jmanager 
# use vcs - ralgen to generate uvm regmodel 
#usage: 
#    ralgen -l sv -uvm -t  S2_8B_MOD_regmodel  S2_8B_MOD8b.ralf
#################################################################################
register REG0 {
    field reg00a  (dout[ 0 ]) {
         bits 1;
         access rw;
         reset 'h0;
    }
    field reg3to2a  (dout[ 3:1 ]) {
         bits 3;
         access rw;
         reset 'h4;
    }
    field reg444ba  (NO_USED_PATH_NEED_TO_BE_REMOVED.reg444ba) {
         bits 1;
         access ro;
         reset 'h1;
    }
    field reserved {
         bits 1;
    }
    field field5a  (dout[ 5:4 ]) {
         bits 2;
         access rw;
         reset 'h0;
    }
}

register REG2 {
    field reg00ab  (dout[ 0 ]) {
         bits 1;
         access rw;
         reset 'h0;
    }
    field reg3to2b  (dout[ 2:1 ]) {
         bits 2;
         access rw;
         reset 'h3;
    }
    field reg444b  (NO_USED_PATH_NEED_TO_BE_REMOVED.reg444b) {
         bits 2;
         access ro;
         reset 'h0;
    }
    field reserved {
         bits 1;
    }
    field field5b  (dout[ 4:3 ]) {
         bits 2;
         access rw;
         reset 'h0;
    }
}

register REG3 {
    field reg00c  (dout[ 0 ]) {
         bits 1;
         access w1c;
         reset 'h0;
    }
    field reserved {
         bits 2;
    }
    field reg444c  (dout[ 1 ]) {
         bits 1;
         access w1c;
         reset 'h0;
    }
    field reserved {
         bits 2;
    }
    field field5c  (dout[ 3:2 ]) {
         bits 2;
         access w1c;
         reset 'h0;
    }
}

register REG1C {
    field reg00c12  (dout[ 5:0 ]) {
         bits 6;
         access rw;
         reset 'h0;
    }
    field field5c12  (NO_USED_PATH_NEED_TO_BE_REMOVED.field5c12) {
         bits 2;
         access ro;
         reset 'h0;
    }
}

register REG1D {
    field xx_name  (dout[ 7:0 ]) {
         bits 8;
         access rw;
         reset 'h9e;
    }
}

register REG1F {
    field reg9e_name2  (dout[ 7:0 ]) {
         bits 8;
         access rw;
         reset 'h9e;
    }
}

register REG21_W1C {
    field reg21w1c  (dout[ 7:0 ]) {
         bits 8;
         access w1c;
         reset 'h0;
    }
}

register STATUS_BYTE {
    field none_of_the_above  (NO_USED_PATH_NEED_TO_BE_REMOVED.none_of_the_above) {
         bits 1;
         access ro;
         reset 'h0;
    }
    field cml  (NO_USED_PATH_NEED_TO_BE_REMOVED.cml) {
         bits 1;
         access ro;
         reset 'h0;
    }
    field tempereature  (NO_USED_PATH_NEED_TO_BE_REMOVED.tempereature) {
         bits 1;
         access ro;
         reset 'h0;
    }
    field vin_uv_fault  (NO_USED_PATH_NEED_TO_BE_REMOVED.vin_uv_fault) {
         bits 1;
         access ro;
         reset 'h3;
    }
    field iout_oc_fault  (NO_USED_PATH_NEED_TO_BE_REMOVED.iout_oc_fault) {
         bits 1;
         access ro;
         reset 'h0;
    }
    field vout_ov_fault  (NO_USED_PATH_NEED_TO_BE_REMOVED.vout_ov_fault) {
         bits 1;
         access ro;
         reset 'h0;
    }
    field off  (NO_USED_PATH_NEED_TO_BE_REMOVED.off) {
         bits 1;
         access ro;
         reset 'h0;
    }
    field busy  (dout[ 0 ]) {
         bits 1;
         access w1c;
         reset 'h0;
    }
}

register FAULT7B {
    field beef0  (dout[ 0 ]) {
         bits 1;
         access w1c;
         reset 'h0;
    }
    field abcf1  (dout[ 1 ]) {
         bits 1;
         access w1c;
         reset 'h0;
    }
    field uvpf2  (dout[ 2 ]) {
         bits 1;
         access w1c;
         reset 'h0;
    }
    field uvpw3  (dout[ 3 ]) {
         bits 1;
         access w1c;
         reset 'h0;
    }
    field uvp4  (dout[ 4 ]) {
         bits 1;
         access w1c;
         reset 'h0;
    }
    field ocv5  (dout[ 5 ]) {
         bits 1;
         access w1c;
         reset 'h0;
    }
    field opt6_f  (dout[ 6 ]) {
         bits 1;
         access w1c;
         reset 'h0;
    }
    field ocp7_f  (dout[ 7 ]) {
         bits 1;
         access w1c;
         reset 'h0;
    }
}

register FRC {
    field rc1  (dout[ 0 ]) {
         bits 1;
         access rc;
         reset 'h0;
    }
    field rc2  (dout[ 1 ]) {
         bits 1;
         access rc;
         reset 'h0;
    }
    field rc3  (dout[ 2 ]) {
         bits 1;
         access rc;
         reset 'h0;
    }
    field rc4  (dout[ 3 ]) {
         bits 1;
         access rc;
         reset 'h0;
    }
    field rc5  (dout[ 4 ]) {
         bits 1;
         access rc;
         reset 'h0;
    }
    field reserved {
         bits 1;
    }
    field rc6  (dout[ 5 ]) {
         bits 1;
         access rc;
         reset 'h0;
    }
    field rc7  (dout[ 6 ]) {
         bits 1;
         access rc;
         reset 'h0;
    }
}

register FAULT33W0C {
    field beef0w0  (dout[ 0 ]) {
         bits 1;
         access w0c;
         reset 'h0;
    }
    field abcf1w0  (dout[ 1 ]) {
         bits 1;
         access w0c;
         reset 'h0;
    }
    field uvpf2w0  (NO_USED_PATH_NEED_TO_BE_REMOVED.uvpf2w0) {
         bits 1;
         access ro;
         reset 'h0;
    }
    field uvpw3wo  (dout[ 2 ]) {
         bits 1;
         access w0c;
         reset 'h0;
    }
    field uvp4w0  (NO_USED_PATH_NEED_TO_BE_REMOVED.uvp4w0) {
         bits 1;
         access ro;
         reset 'h0;
    }
    field w0ocv5  (dout[ 3 ]) {
         bits 1;
         access w0c;
         reset 'h0;
    }
    field w0opt6_f  (dout[ 4 ]) {
         bits 1;
         access w0c;
         reset 'h0;
    }
    field w0cocp7_f  (dout[ 5 ]) {
         bits 1;
         access w0c;
         reset 'h0;
    }
}

block S2_8B_MOD_regmodel {
    bytes 1;
    register REG0 (U_REG0_0)		@'h0;
    register REG2 (U_REG2_1)		@'h1;
    register REG3 (U_REG3_3)		@'h3;
    register REG1C (U_REG1C_1C)		@'h1c;
    register REG1D (U_REG1D_1D)		@'h1d;
    register REG1F (U_REG1F_1F)		@'h1f;
    register REG21_W1C (U_REG21_W1C_21)		@'h21;
    register STATUS_BYTE (U_STATUS_BYTE_33)		@'h33;
    register FAULT7B (U_FAULT7B_34)		@'h34;
    register FRC (U_FRC_36)		@'h36;
    register FAULT33W0C (U_FAULT33W0C_37)		@'h37;
}
